*=====================================================
* Sanity Check CMOS Inverter Formation
* Memverifikasi topologi inverter CMOS dari subckt schematic
*=====================================================

.option savecurrents
.temp 27

.param VDD=1.8

* Supply + stimulus
VDD vdd 0 {VDD}
VIN in  0 PULSE(0 {VDD} 0 20p 20p 5n 10n)
CL  out 0 10f

* Model demo agar netlist bisa disimulasikan tanpa PDK
.model nmos_03v3 nmos level=1 vto=0.45 kp=200u lambda=0.04 gamma=0.4 phi=0.7
.model pmos_03v3 pmos level=1 vto=-0.45 kp=90u  lambda=0.05 gamma=0.4 phi=0.7

* Ambil subcircuit inverter dari netlist schematic
.include "xschem/inverter_sch.spice"
XINV in out vdd 0 inverter

.tran 10p 30n

.control
run

* Cek level output pada dua kondisi input
* Vin tinggi pada sekitar 0..5ns, lalu rendah pada 5..10ns
meas tran VOUT_WHEN_IN_HIGH find v(out) at=2n
meas tran VOUT_WHEN_IN_LOW  find v(out) at=7n

* Cek timing dasar
meas tran tPHL trig v(in) val=0.9 rise=1 targ v(out) val=0.9 fall=1
meas tran tPLH trig v(in) val=0.9 fall=1 targ v(out) val=0.9 rise=1

* Rise/Fall time output (10%-90% dan 90%-10%)
meas tran tRise trig v(out) val=0.18 rise=1 targ v(out) val=1.62 rise=1
meas tran tFall trig v(out) val=1.62 fall=1 targ v(out) val=0.18 fall=1

wrdata spice/inverter_cmos_sanity.csv time v(in) v(out)
.endc

.end
